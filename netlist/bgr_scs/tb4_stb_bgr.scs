// TB4: STB BGR Stability Analysis
// Probe: BGR internal IPRB0 (xBGR.IPRB0)
// Temperature: 27C, Corner: TT
// BGR + HORDER joint simulation
// STB frequency: 1 mHz to 1 GHz

parameters vdd_val=2 vddb_val=3.3

// PDK includes - 5 sections required for BGR+HORDER joint simulation
include "/share/project/ianalog/process/SMIC/smic18mserf_1833_1P6M_5Ia_1TMa2_MIM20_TYP1_oa_cds_2022_01_20_v1.20_rev0_0/models/spectre/ms018_enhanced_v1p2_rev0_spe.lib" section=tt
include "/share/project/ianalog/process/SMIC/smic18mserf_1833_1P6M_5Ia_1TMa2_MIM20_TYP1_oa_cds_2022_01_20_v1.20_rev0_0/models/spectre/ms018_enhanced_v1p2_rev0_spe.lib" section=res_tt
include "/share/project/ianalog/process/SMIC/smic18mserf_1833_1P6M_5Ia_1TMa2_MIM20_TYP1_oa_cds_2022_01_20_v1.20_rev0_0/models/spectre/ms018_enhanced_v1p2_rev0_spe.lib" section=mim_tt
include "/share/project/ianalog/process/SMIC/smic18mserf_1833_1P6M_5Ia_1TMa2_MIM20_TYP1_oa_cds_2022_01_20_v1.20_rev0_0/models/spectre/ms018_enhanced_v1p2_rev0_spe.lib" section=bjt_tt
include "/share/project/ianalog/process/SMIC/smic18mserf_1833_1P6M_5Ia_1TMa2_MIM20_TYP1_oa_cds_2022_01_20_v1.20_rev0_0/models/spectre/ms018_enhanced_v1p2_rev0_spe.lib" section=dio_tt
include "/share/project/ianalog/process/SMIC/smic18mserf_1833_1P6M_5Ia_1TMa2_MIM20_TYP1_oa_cds_2022_01_20_v1.20_rev0_0/models/spectre/ms018_enhanced_v1p2_rev0_spe.lib" section=var_tt

// Include DUT and BGR subcircuit definitions
include "./dut.scs"
include "./bgr.scs"

// BGR instance (BANDGAP_7070_MK3)
// Ports: DEC_D0 DEC_D1 DEC_D2 GND OEN PIB VBG VDDB VR0 VR1 VCTAT VREF
xBGR (DEC_D0 DEC_D1 DEC_D2 GND OEN PIB VBG VDDB VR0 VR1 VCTAT VREF) BANDGAP_7070_MK3

// HORDER instance (wrapper subckt with STB ports)
// Last two wrapper ports (_vdd_, _vss_) connect to VDD and VSS respectively
xdut (IBN_3U_CENTER VINP_CENTER V_CONTROL CTRL_H4 CTRL_H5 \
    IBN_1U_H3 IBN_1U_H4 IBN_1U_H5 \
    IBN_6U_CONT IBN_6U_H1 IBN_6U_H3 IBN_6U_H4 IBN_6U_H5 \
    IBN_6U_VOL3 IBN_6U_VOL41 IBN_6U_VOL42 IBN_6U_VOL51 IBN_6U_VOL52 \
    IBP_3U_ADDER NCTRL_H4 NCTRL_H5 \
    VDD VH1 VH2 VH3 VCTAT VL1 VL2 VL3 VM \
    VOUT_ADDER VOUT_CONT VOUT_H1 VOUT_H3 VOUT_H4 VOUT_H5 \
    VSS \
    STB1_CONT STB2_CONT STB1_H1 STB2_H1 \
    STB1_H3_AMP STB2_H3_AMP STB1_H4_AMP1 STB2_H4_AMP1 \
    STB1_H5_AMP1 STB2_H5_AMP1 STB1_ADDER STB2_ADDER \
    STB1_H3 STB2_H3 STB1_H4 STB2_H4 \
    STB1_H4_AMP2 STB2_H4_AMP2 STB1_H5 STB2_H5 \
    STB1_H5_AMP2 STB2_H5_AMP2 STB1_CENTER STB2_CENTER \
    VDD VSS) NewGenerator_20260610_175018_wrapper_9f8ecae021113917

// BGR power supply
V_VDDB (VDDB 0) vsource dc=3.3
V_GND (GND 0) vsource dc=0

// BGR control signals
V_OEN (OEN 0) vsource dc=3.3
V_VREF (VREF 0) vsource dc=1
V_DEC0 (DEC_D0 0) vsource dc=0
V_DEC1 (DEC_D1 0) vsource dc=0
V_DEC2 (DEC_D2 0) vsource dc=0

// HORDER power supply
V_VDD (VDD 0) vsource dc=2
V_VSS (VSS 0) vsource dc=0

// HORDER input references
V_VINP_CENTER (VINP_CENTER 0) vsource dc=1.28
V_VM (VM 0) vsource dc=1.3
V_VH1 (VH1 0) vsource dc=1.7
V_VH2 (VH2 0) vsource dc=1.8
V_VH3 (VH3 0) vsource dc=1.9
V_VL1 (VL1 0) vsource dc=0.9
V_VL2 (VL2 0) vsource dc=0.8
V_VL3 (VL3 0) vsource dc=0.7

// HORDER control signals
V_CTRL_H4 (CTRL_H4 0) vsource dc=0
V_NCTRL_H4 (NCTRL_H4 0) vsource dc=2
V_CTRL_H5 (CTRL_H5 0) vsource dc=0
V_NCTRL_H5 (NCTRL_H5 0) vsource dc=2

// HORDER bias currents
// IBN_1U: 1uA from VDD to port
I_IBN_1U_H3 (VDD IBN_1U_H3) isource dc=1u
I_IBN_1U_H4 (VDD IBN_1U_H4) isource dc=1u
I_IBN_1U_H5 (VDD IBN_1U_H5) isource dc=1u

// IBN_6U: 6uA from VDD to port
I_IBN_6U_H1 (VDD IBN_6U_H1) isource dc=6u
I_IBN_6U_H3 (VDD IBN_6U_H3) isource dc=6u
I_IBN_6U_H4 (VDD IBN_6U_H4) isource dc=6u
I_IBN_6U_H5 (VDD IBN_6U_H5) isource dc=6u
I_IBN_6U_CONT (VDD IBN_6U_CONT) isource dc=6u
I_IBN_6U_VOL3 (VDD IBN_6U_VOL3) isource dc=6u
I_IBN_6U_VOL41 (VDD IBN_6U_VOL41) isource dc=6u
I_IBN_6U_VOL42 (VDD IBN_6U_VOL42) isource dc=6u
I_IBN_6U_VOL51 (VDD IBN_6U_VOL51) isource dc=6u
I_IBN_6U_VOL52 (VDD IBN_6U_VOL52) isource dc=6u

// IBP_3U_ADDER: 3uA from port to VSS
I_IBP_3U_ADDER (IBP_3U_ADDER 0) isource dc=3u

// IBN_3U_CENTER: 3uA from port to VSS
I_IBN_3U_CENTER (IBN_3U_CENTER 0) isource dc=3u

// Unused HORDER STB ports - connect to VSS to close loops
// (iprobe acts as DC short, probes unused in this TB)
V_STB1_CONT (STB1_CONT 0) vsource dc=0
V_STB2_CONT (STB2_CONT 0) vsource dc=0
V_STB1_H1 (STB1_H1 0) vsource dc=0
V_STB2_H1 (STB2_H1 0) vsource dc=0
V_STB1_H3_AMP (STB1_H3_AMP 0) vsource dc=0
V_STB2_H3_AMP (STB2_H3_AMP 0) vsource dc=0
V_STB1_H4_AMP1 (STB1_H4_AMP1 0) vsource dc=0
V_STB2_H4_AMP1 (STB2_H4_AMP1 0) vsource dc=0
V_STB1_H5_AMP1 (STB1_H5_AMP1 0) vsource dc=0
V_STB2_H5_AMP1 (STB2_H5_AMP1 0) vsource dc=0
V_STB1_ADDER (STB1_ADDER 0) vsource dc=0
V_STB2_ADDER (STB2_ADDER 0) vsource dc=0
V_STB1_H3 (STB1_H3 0) vsource dc=0
V_STB2_H3 (STB2_H3 0) vsource dc=0
V_STB1_H4 (STB1_H4 0) vsource dc=0
V_STB2_H4 (STB2_H4 0) vsource dc=0
V_STB1_H4_AMP2 (STB1_H4_AMP2 0) vsource dc=0
V_STB2_H4_AMP2 (STB2_H4_AMP2 0) vsource dc=0
V_STB1_H5 (STB1_H5 0) vsource dc=0
V_STB2_H5 (STB2_H5 0) vsource dc=0
V_STB1_H5_AMP2 (STB1_H5_AMP2 0) vsource dc=0
V_STB2_H5_AMP2 (STB2_H5_AMP2 0) vsource dc=0
V_STB1_CENTER (STB1_CENTER 0) vsource dc=0
V_STB2_CENTER (STB2_CENTER 0) vsource dc=0

// Save signals for monitoring
save VBG VCTAT V_CONTROL V_VDDB:p V_VDD:p

// STB analysis on BGR internal iprobe IPRB0
stb_bgr stb start=1e-3 stop=1e9 probe=xBGR.IPRB0
