* Two-Stage Op Amp — DC Operating Point (BSIM4v5 / PTM 130nm)

VDD_SRC vdd 0 DC 1.3
VSS_SRC vss 0 DC 0
VINP_SRC inp 0 DC 0.65
VINN_SRC inn 0 DC 0.65

.include /mnt/e/MyResearch/Mixed_ngspice/test/bsim4/circuits/opamp_dut_bsim4.cir
XOPAMP inp inn out vdd vss opamp_bsim4

RLOAD out vss 100k
CLOAD out vss 1p

.include /mnt/e/MyResearch/Mixed_ngspice/test/models/ptm130.lib
.options RELTOL=1e-4 ABSTOL=1e-12 VNTOL=1e-7 ITL4=80

.control
op
print v(out) v(inn) v(inp) i(VDD_SRC)
.endc
.end
