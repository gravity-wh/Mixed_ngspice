* Five-Transistor OTA — DC Transfer Testbench (BSIM4v5 / PTM 130nm)
* Vdd=1.3V, common-mode=0.65V

VDD_SRC   vdd   0 DC 1.3
VSS_SRC   vss   0 DC 0
VBIAS_SRC vbias 0 DC 0.55
VINP_SRC  inp   0 DC 0.65
VINN_SRC  inn   0 DC 0.65

.include /mnt/e/MyResearch/Mixed_ngspice/test/bsim4/circuits/ota_dut_bsim4.cir
XOTA inp inn out vdd vss vbias ota_bsim4

RLOAD out vss 1e+09
CLOAD out vss 0.5e-12

.include /mnt/e/MyResearch/Mixed_ngspice/test/models/ptm130.lib
.options RELTOL=1e-4 ABSTOL=1e-12 VNTOL=1e-7 ITL4=80

.control
op
print v(out)
dc VINP_SRC 0.55 0.75 0.0005
wrdata ota_dc_vinp.txt v(inp)
wrdata ota_dc_vout.txt v(out)
.endc

.end
