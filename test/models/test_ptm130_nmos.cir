* Single NMOS test — PTM 130nm BSIM4
.include ptm130.lib
Vdd d 0 DC 1.3
Vgs g 0 DC 1.3
M1 d g 0 0 nmos W=10u L=130n
.options reltol=1e-4 abstol=1e-12
.control
op
print v(d) i(Vdd)
.endc
.end
