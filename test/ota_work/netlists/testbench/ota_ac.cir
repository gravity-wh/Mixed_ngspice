* Five-Transistor OTA — AC Open-Loop Testbench
*
* Differential AC stimulus:
*   INP = VCM + +0.5 Vac
*   INN = VCM + -0.5 Vac
* Therefore v(out) is directly V/V differential gain.

VDD_SRC   vdd   0 DC 1.8
VSS_SRC   vss   0 DC 0
VBIAS_SRC vbias 0 DC 0.72
VINP_SRC  inp   0 DC 0.9 AC 0.5
VINN_SRC  inn   0 DC 0.9 AC 0.5 180

.include /mnt/e/MyResearch/Mixed_ngspice/test/ota_work/netlists/dut/five_transistor_ota_dut.cir
XOTA inp inn out vdd vss vbias five_transistor_ota

RLOAD out vss 1e+09
CLOAD out vss 1.000000e-12

.include /mnt/e/MyResearch/analog-circuit-skills/five_transistor_ota/assets/models/ptm180.lib
.options RELTOL=1e-4 ABSTOL=1e-12 VNTOL=1e-7 ITL4=80

.control
ac dec 100 1 1e+09
wrdata /mnt/e/MyResearch/Mixed_ngspice/test/ota_work/logs/ota_ac_freq.txt frequency
wrdata /mnt/e/MyResearch/Mixed_ngspice/test/ota_work/logs/ota_ac_gain_db.txt vdb(out)
wrdata /mnt/e/MyResearch/Mixed_ngspice/test/ota_work/logs/ota_ac_phase.txt vp(out)
.endc

.end
