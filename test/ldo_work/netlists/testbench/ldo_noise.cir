* LDO Noise Testbench
* Technology: PTM 180nm, VIN=2.3V, VREF=0.9V
* Measures output-referred noise spectral density via ngspice .noise analysis.
*   onoise_spectrum : output noise amplitude density [V/sqrt(Hz)]  (V+ = vout, V- = vss)
*
* Note: ngspice 43+ returns onoise_spectrum already in V/sqrt(Hz), NOT V^2/Hz.

* ── DC Sources ───────────────────────────────────────────────────────────────
* V1 is the noise reference source (required by .noise command)
V1       vin  0  DC 2.3  AC 1
VREF_SRC vref 0  DC 0.9
VVSS     vss  0  DC 0

* ── Load ─────────────────────────────────────────────────────────────────────
R_load  vout vss  18

* ── DUT ──────────────────────────────────────────────────────────────────────
.include /mnt/e/MyResearch/Mixed_ngspice/test/ldo_work/netlists/dut/ldo_dut.cir
X1 vin vout vss vref ldo_18_3

.include /mnt/e/MyResearch/analog-circuit-skills/LDO/assets/models/ptm180.lib
.options RELTOL=1e-4 ABSTOL=1e-12 VNTOL=1e-7 ITL4=50

* ── Noise Analysis ───────────────────────────────────────────────────────────
* V(vout, vss): differential output noise (positive=vout, negative=vss)
* V1 is required as a reference source by ngspice .noise syntax only;
* it does not affect onoise_spectrum (total output noise from all sources).
.control
noise V(vout, vss) V1 dec 100 1 1e+08
setplot noise1
wrdata /mnt/e/MyResearch/Mixed_ngspice/test/ldo_work/logs/ldo_noise_freq.txt   frequency
wrdata /mnt/e/MyResearch/Mixed_ngspice/test/ldo_work/logs/ldo_noise_onoise.txt       onoise_spectrum
.endc

.end
