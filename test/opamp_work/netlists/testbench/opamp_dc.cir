* Two-Stage Op Amp — DC Operating Point

VDD_SRC vdd 0 DC 1.8
VSS_SRC vss 0 DC 0
VINP_SRC inp 0 DC 0.9
VINN_SRC inn 0 DC 0.9

.include /mnt/e/MyResearch/Mixed_ngspice/test/opamp_work/netlists/dut/two_stage_opamp_dut.cir
XOP inp inn out vdd vss two_stage_opamp

CLOAD out vss 1.200000e-12
RLEAK out vss 1e+09

.include /mnt/e/MyResearch/analog-circuit-skills/two_stage_opamp/assets/models/ptm180.lib
.options RELTOL=1e-4 ABSTOL=1e-12 VNTOL=1e-7 ITL4=80

.control
op
wrdata /mnt/e/MyResearch/Mixed_ngspice/test/opamp_work/logs/opamp_dc_nodes.txt v(inp) v(inn) v(xop.c) v(xop.a) v(xop.b) v(out) v(xop.pbias)
wrdata /mnt/e/MyResearch/Mixed_ngspice/test/opamp_work/logs/opamp_dc_currents.txt i(VDD_SRC)
.endc

.end
