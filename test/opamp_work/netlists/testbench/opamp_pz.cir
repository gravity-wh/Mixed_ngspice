* Two-Stage Op Amp — Pole-Zero Analysis
*
* ngspice pz analysis is run with a single-ended small-signal source.
* The pole locations are used together with the differential AC sweep.

VDD_SRC vdd 0 DC 1.8
VINP_SRC inp 0 DC 0.9 AC 1
VINN_SRC inn 0 DC 0.9 AC 0

.include /mnt/e/MyResearch/Mixed_ngspice/test/opamp_work/netlists/dut/two_stage_opamp_dut.cir
XOP inp inn out vdd 0 two_stage_opamp

CLOAD out 0 1.200000e-12
RLEAK out 0 1e+09

.include /mnt/e/MyResearch/analog-circuit-skills/two_stage_opamp/assets/models/ptm180.lib
.options RELTOL=1e-4 ABSTOL=1e-12 VNTOL=1e-7 ITL4=80

.control
pz inp 0 out 0 vol pz
display
print all
.endc

.end
