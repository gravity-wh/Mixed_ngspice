* Two-Stage Op Amp — AC Open-Loop Gain/Phase
*
* Differential AC stimulus:
*   INP = VCM + +0.5 Vac
*   INN = VCM + -0.5 Vac
* Therefore V(out) is directly V/V differential gain.

VDD_SRC vdd 0 DC 1.8
VSS_SRC vss 0 DC 0
VINP_SRC inp 0 DC 0.9 AC 0.5
VINN_SRC inn 0 DC 0.9 AC 0.5 180

.include /mnt/e/MyResearch/Mixed_ngspice/test/opamp_work/netlists/dut/two_stage_opamp_dut.cir
XOP inp inn out vdd vss two_stage_opamp

CLOAD out vss 1.200000e-12
RLEAK out vss 1e+09

.include /mnt/e/MyResearch/analog-circuit-skills/two_stage_opamp/assets/models/ptm180.lib
.options RELTOL=1e-4 ABSTOL=1e-12 VNTOL=1e-7 ITL4=80

.control
ac dec 120 1 1e+10
wrdata /mnt/e/MyResearch/Mixed_ngspice/test/opamp_work/logs/opamp_ac_freq.txt frequency
wrdata /mnt/e/MyResearch/Mixed_ngspice/test/opamp_work/logs/opamp_ac_gain_db.txt vdb(out)
wrdata /mnt/e/MyResearch/Mixed_ngspice/test/opamp_work/logs/opamp_ac_phase.txt vp(out)
.endc

.end
