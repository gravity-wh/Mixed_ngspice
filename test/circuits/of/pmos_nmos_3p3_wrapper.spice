* Minimal compatibility wrapper for hybridCHIPS/MAGICAL circuits
* Maps old subcircuit names → standard BSIM4 models
.subckt pmos_3p3 D G S B w=1u l=0.15u
M1 D G S B pmos W={w} L={l}
.ends pmos_3p3

.subckt pmos_6p0 D G S B w=1u l=0.15u
M1 D G S B pmos W={w} L={l}
.ends pmos_6p0

.subckt nmos_3p3 D G S B w=1u l=0.15u
M1 D G S B nmos W={w} L={l}
.ends nmos_3p3
