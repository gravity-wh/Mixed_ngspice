.include ideal_opamp.spice
* Auto TB for Ideal_opamp
.include /mnt/e/MyResearch/Mixed_ngspice/test/models/45nm_LP_BSIM4/ptm45lp.lib
.option gmin=1e-12
**.subckt Ideal_opamp Vp Vn Out
*.ipin Vp
*.ipin Vn
*.opin Out
V1 Vp PLUS_I 0
V2 Vn MINUS_I 0
B1 Out 0 V = 'VDD/2*(1+tanh(GAIN*(V(PLUS_I)-V(MINUS_I))))'
**.ends
** flattened .save nodes
.save I(V1)
.save I(V2)
.end

Vdd Vp 0 DC 1.8
Vss Vn 0 DC 0
X1 Vp Vn Out Ideal_opamp
.op
.control
op
.endc
.end
