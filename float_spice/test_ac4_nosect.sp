* AC4: Nonexistent section in existing file
.lib '../test/models/45nm_LP_BSIM4/test_section.lib' nonexistent_section
VDD VDD 0 1.1
M1  D 0 0 0 nmos W=1u L=45n
VD D 0 1.1
.op
.end
