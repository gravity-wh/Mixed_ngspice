* AC3: Nonexistent file
.lib '/nonexistent/file.lib' tt
VDD VDD 0 1.1
M1  D 0 0 0 nmos W=1u L=45n
VD D 0 1.1
.op
.end
